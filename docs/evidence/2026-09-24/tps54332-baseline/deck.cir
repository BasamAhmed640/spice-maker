* Frozen fixture: Measure adjustable output voltage at the 0.8 V minimum set point.
.include "TPS54332DDA.lib"
V1 VIN 0 5
Cvin VIN 0 10u
Cboot BOOT PH 0.1u
Css SS 0 10n
Rcomp COMP 0 10k
Ccomp COMP 0 1n
Rfb1 VOUT VSENSE 1u
L1 PH VOUT 10u
Cout VOUT 0 100u
Bcatch PH 0 I=if(V(PH)<0,V(PH)/0.1,0)
Rload VOUT 0 1.6
Xdut BOOT VIN EN SS VSENSE COMP 0 PH 0 TPS54332DDA
.temp 25
.options plotwinsize=0 numdgt=15
.tran 0 0.01 0 1e-06
.save V(VOUT)
.end
