* Dual op amp quiescent; channel 1
.include "C:/Users/basam/src/.smsnap/general/models/C-lm358/build/model/LM358.lib"
Vcc vcc 0 5
Vref ref 0 2.5
Xamp vcc out inm inp 0 ref other other LM358
Rload out 0 1e+12
Vin inp 0 2.5
Vfeedback inm out 0
.tran 0 0.0001 0 1e-08
.temp 25
.options plotwinsize=0 numdgt=15 method=gear gminsteps=0 srcsteps=0
.save V(inp) V(inm) V(out) I(Vcc)
.end
