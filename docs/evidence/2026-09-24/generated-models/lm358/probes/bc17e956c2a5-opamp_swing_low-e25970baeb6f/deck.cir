* Dual op amp swing low; channel 2
.include "C:/Users/basam/src/.smsnap/general/models/C-lm358/build/model/LM358.lib"
Vcc vcc 0 5
Vref ref 0 2.5
Xamp vcc other other ref 0 inp inm out LM358
Rload out 0 10000
Vin inp 0 0
Vminus inm 0 1
.tran 0 0.0001 0 1e-08
.temp 25
.options plotwinsize=0 numdgt=15 method=gear gminsteps=0 srcsteps=0
.save V(inp) V(inm) V(out) I(Vcc)
.end
