* Dual op amp slew rise; channel 2
.include "C:/Users/basam/AppData/Local/Temp/fzgh/general/tree-v5t4sexd/spice-maker-convergence-shared-core/models/G-lm358/build/model/LM358.lib"
Vcc vcc 0 5
Vref ref 0 2.5
Xamp other other ref 0 inp inm out vcc LM358
Rload out 0 1e+12
Vin inp 0 PULSE(1 3 20u 1n 1n 40u 100u)
Vfeedback inm out 0
.tran 0 0.0001 0 1e-08
.temp 25
.options plotwinsize=0 numdgt=15 method=gear gminsteps=0 srcsteps=0
.save V(inp) V(inm) V(out) I(Vcc)
.end
